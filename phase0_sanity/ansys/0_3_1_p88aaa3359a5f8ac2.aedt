# Ansys Electronics Desktop project, version 2025.2
project datasets:
  $mu_r_real: units GHz, fraction: (1000000, 133) (3000000, 134) (5000000, 135) (8000000, 136) (10000000, 137) (12000000, 142) (15000000, 152) (18000000, 160) (20000000, 166) (25000000, 150) (30000000, 130) (40000000, 100) (50000000, 82) (70000000, 65) (100000000, 50) (150000000, 35) (200000000, 25) (300000000, 15) (500000000, 10) (700000000, 11) (1000000000, 18)
  $mu_tand_m: units GHz, fraction: (1000000, 0) (3000000, 0) (5000000, 0) (8000000, 0.00367647) (10000000, 0.00729927) (12000000, 0.0140845) (15000000, 0.0328947) (18000000, 0.075) (20000000, 0.150602) (25000000, 0.4) (30000000, 0.553846) (40000000, 0.76) (50000000, 0.890244) (70000000, 1.01538) (100000000, 1.16) (150000000, 1.42857) (200000000, 1.8) (300000000, 2.46667) (500000000, 2.8) (700000000, 2) (1000000000, 1)
materials:
  vacuum: permittivity=1
  fr4: permittivity=4.4 permeability=1 dielectric_loss_tangent=0.02
  copper: permeability=0.999991 conductivity=58000000
  MULL12060ferrite: permittivity=6 permeability="pwlx($mu_r_real, Freq)" conductivity=0.01 magnetic_loss_tangent="pwlx($mu_tand_m, Freq)"
  air: permittivity=1.0006 permeability=1.0000004

design 0_3_1_p88aaa3359a5f8ac2 (HFSS, HFSS Terminal Network, model units mm)
datasets:
  mu_p: units GHz, fraction: (1000000, 133) (3000000, 134) (5000000, 135) (8000000, 136) (10000000, 137) (12000000, 142) (15000000, 152) (18000000, 160) (20000000, 166) (25000000, 150) (30000000, 130) (40000000, 100) (50000000, 82) (70000000, 65) (100000000, 50) (150000000, 35) (200000000, 25) (300000000, 15) (500000000, 10) (700000000, 11) (1000000000, 18)
geometry:
  rx_ssw_coil_ssw_copper [copper, solve inside] = imported_body(/home/harry/Projects/PythonProjects/worktrees3/dev_3/run/ssw_0_3_0_fixed/ssw_scene.step)
  rx_ssw_coil_pcb_2_fr4, rx_ssw_coil_pcb_1_fr4 [fr4] = imported_body(/home/harry/Projects/PythonProjects/worktrees3/dev_3/run/ssw_0_3_0_fixed/ssw_scene.step)
  tx_ssw_coil_ssw_copper [copper, solve inside] = imported_body(/home/harry/Projects/PythonProjects/worktrees3/dev_3/run/ssw_0_3_0_fixed/ssw_scene.step)
  tx_ssw_coil_pcb_2_fr4, tx_ssw_coil_pcb_1_fr4 [fr4] = imported_body(/home/harry/Projects/PythonProjects/worktrees3/dev_3/run/ssw_0_3_0_fixed/ssw_scene.step)
  tx_mull_ferrite_sheet [MULL12060ferrite] = imported_body(/home/harry/Projects/PythonProjects/worktrees3/dev_3/run/ssw_0_3_0_fixed/ssw_scene.step)
  rx_region_max, tx_region_max, tx_region, tv [vacuum, non-model] = imported_body(/home/harry/Projects/PythonProjects/worktrees3/dev_3/run/ssw_0_3_0_fixed/ssw_scene.step)
  Region_Abs_2000mm [air] = region(absolute_offset=2000mm on all sides)
  LP1 = polyline(z=231.45mm, xy in mm: (21.610416, 126.18016) (14.438774, 133.88059) (12.208424, 133.99002) (19.644462, 126.28958), closed, covered)
  LP2 = polyline(x=8.93mm, yz in mm: (130.78691, 374.88275) (141.0573, 365.35492) (141.25826, 362.99011) (130.98787, 372.88922), closed, covered)
  Rectangle1 [non-model] = rectangle(corner=(-100mm, 0mm, 500mm), z_size=-350mm, x_size=250mm)
boundaries and excitations:
  Rad_RegionAbs_0: Radiation Faces=Region_Abs_2000mm.face(+z)
  Rad_RegionAbs_1: Radiation Faces=Region_Abs_2000mm.face(-y)
  Rad_RegionAbs_2: Radiation Faces=Region_Abs_2000mm.face(-x)
  Rad_RegionAbs_3: Radiation Faces=Region_Abs_2000mm.face(+y)
  Rad_RegionAbs_4: Radiation Faces=Region_Abs_2000mm.face(-z)
  Rad_RegionAbs_5: Radiation Faces=Region_Abs_2000mm.face(+x)
  1_T1: Terminal port=1 Edges=tx_ssw_coil_ssw_copper.edge(at (18.0246, 130.03, 231.45)) TerminalResistance=50ohm
  2_T1: Terminal port=2 Edges=rx_ssw_coil_ssw_copper.edge(at (8.93, 135.922, 370.119)) TerminalResistance=50ohm
  1: Lumped Port Faces=LP1.face LumpedPortType=Terminal Impedance=50ohm
  2: Lumped Port Faces=LP2.face LumpedPortType=Terminal Impedance=50ohm
mesh:
  Length1: LengthBased Objects=[rx_ssw_coil_ssw_copper, tx_ssw_coil_ssw_copper, tx_ssw_coil_pcb_1_fr4, tx_ssw_coil_pcb_2_fr4, rx_ssw_coil_pcb_1_fr4, rx_ssw_coil_pcb_2_fr4] NumMaxElem=50000 MaxLength=1mm
setups:
  Setup1: HfssDriven Frequency=6.78MHz MaxDeltaS=0.005 MaximumPasses=35 MinimumPasses=17 MinimumConvergedPasses=7 PercentRefinement=30 BasisOrder=0 DoLambdaRefine=false PortAccuracy=2 DrivenSolverType="Direct Solver"
    sweep Sweep: 0.1MHz to 100MHz, 81 points; Type=Interpolating InterpTolerance=0.5 InterpMaxSolns=250 PassivityErrorTolerance=0.0001
source amplitudes:
  1:1: 100V 0deg
  2:1: 100V 90deg
output variables:
  Ltx_uH = im(Zt(1_T1,1_T1))/2/pi/freq*1e6
  Lrx_uH = im(Zt(2_T1,2_T1))/2/pi/freq*1e6
  M_uH = abs(im(Zt(1_T1,2_T1))/2/pi/freq*1e6)
  k_ratio = M_uH/sqrt(Ltx_uH*Lrx_uH)
  Qtx_ratio = im(Zt(1_T1,1_T1))/re(Zt(1_T1,1_T1))
  Qrx_ratio = im(Zt(2_T1,2_T1))/re(Zt(2_T1,2_T1))
  FOM_ratio = k_ratio*sqrt(Qtx_ratio*Qrx_ratio)
  re_Z11_ohm = re(Zt(1_T1,1_T1))
  im_Z11_ohm = im(Zt(1_T1,1_T1))
  re_Z22_ohm = re(Zt(2_T1,2_T1))
  im_Z22_ohm = im(Zt(2_T1,2_T1))
  re_Z12_ohm = re(Zt(1_T1,2_T1))
  im_Z12_ohm = im(Zt(1_T1,2_T1))
  M_over_Ltx_ratio = M_uH/Ltx_uH
  M_over_Lrx_ratio = M_uH/Lrx_uH
  eta_fom_max_ratio = (FOM_ratio*FOM_ratio)/((1+sqrt(1+FOM_ratio*FOM_ratio))*(1+sqrt(1+FOM_ratio*FOM_ratio)))
field calculator expressions:
  loss_W_rx_ssw_coil_pcb_1_fr4 = Volume_Loss_Density | EnterVolume(rx_ssw_coil_pcb_1_fr4) | VolumeValue | Integrate
  loss_W_rx_ssw_coil_pcb_2_fr4 = Volume_Loss_Density | EnterVolume(rx_ssw_coil_pcb_2_fr4) | VolumeValue | Integrate
  loss_W_rx_ssw_coil_ssw_copper = Volume_Loss_Density | EnterVolume(rx_ssw_coil_ssw_copper) | VolumeValue | Integrate
  loss_W_tx_mull_ferrite_sheet = Volume_Loss_Density | EnterVolume(tx_mull_ferrite_sheet) | VolumeValue | Integrate
  loss_W_tx_ssw_coil_pcb_1_fr4 = Volume_Loss_Density | EnterVolume(tx_ssw_coil_pcb_1_fr4) | VolumeValue | Integrate
  loss_W_tx_ssw_coil_pcb_2_fr4 = Volume_Loss_Density | EnterVolume(tx_ssw_coil_pcb_2_fr4) | VolumeValue | Integrate
  loss_W_tx_ssw_coil_ssw_copper = Volume_Loss_Density | EnterVolume(tx_ssw_coil_ssw_copper) | VolumeValue | Integrate
  loss_W_Region_Abs_2000mm = Volume_Loss_Density | EnterVolume(Region_Abs_2000mm) | VolumeValue | Integrate
field plots:
  Vector_H1: H Field over a plane on Setup1 : LastAdaptive at Freq=0.00678GHz Phase=0deg
reports:
  Results1_Pass: Ltx_uH, Lrx_uH, M_uH, k_ratio, Qtx_ratio, Qrx_ratio, FOM_ratio, re_Z11_ohm, im_Z11_ohm, re_Z22_ohm, im_Z22_ohm, re_Z12_ohm, im_Z12_ohm, M_over_Ltx_ratio, M_over_Lrx_ratio, eta_fom_max_ratio, SolvedElements, MaxMagDeltaS vs Pass on Setup1 : AdaptivePass [Freq=all]
  Results2_Last: loss_W_rx_ssw_coil_pcb_1_fr4, loss_W_rx_ssw_coil_pcb_2_fr4, loss_W_rx_ssw_coil_ssw_copper, loss_W_tx_mull_ferrite_sheet, loss_W_tx_ssw_coil_pcb_1_fr4, loss_W_tx_ssw_coil_pcb_2_fr4, loss_W_tx_ssw_coil_ssw_copper, loss_W_Region_Abs_2000mm vs Freq on Setup1 : LastAdaptive [Phase=0deg]
  Results3_Freq: Ltx_uH, Lrx_uH, M_uH, k_ratio, Qtx_ratio, Qrx_ratio, FOM_ratio, re_Z11_ohm, im_Z11_ohm, re_Z22_ohm, im_Z22_ohm, re_Z12_ohm, im_Z12_ohm, M_over_Ltx_ratio, M_over_Lrx_ratio, eta_fom_max_ratio, Volume(tx_mull_ferrite_sheet), Volume(tx_ssw_coil_ssw_copper), Volume(rx_ssw_coil_ssw_copper), Volume(Region_Abs_2000mm) vs Freq on Setup1 : Sweep
  Terminal Z Parameter Plot1: im(Zt(1_T1,1_T1)), im(Zt(2_T1,1_T1)), im(Zt(2_T1,2_T1)) vs Freq on Setup1 : Sweep
